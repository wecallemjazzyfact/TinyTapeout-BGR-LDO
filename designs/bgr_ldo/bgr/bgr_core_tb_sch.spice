** sch_path: /foss/designs/designs/bgr_ldo/sim/bgr_core_tb.sch
**.subckt bgr_core_tb
XXQA 0 0 VBE1 sky130_fd_pr__pnp_05v5_W0p68L0p68 m=1 mult=1
VSource VAPWR 0 3.3
XXQB 0 0 VBE8 sky130_fd_pr__pnp_05v5_W0p68L0p68 m=8 mult=8
R1 net1 VBE8 17.7k
R7 net1 0 120k
R6 VBE1 0 120k
XXM_top1 net3 net2 VAPWR VAPWR sky130_fd_pr__pfet_g5v0d10v5 L=2 W=10 nf=1 ad=2.9 as=2.9 pd=20.58 ps=20.58 nrd=0.029 nrs=0.029 sa=0
+ sb=0 sd=0 mult=4 m=4
XXM_top2 net2 net2 VAPWR VAPWR sky130_fd_pr__pfet_g5v0d10v5 L=2 W=10 nf=1 ad=2.9 as=2.9 pd=20.58 ps=20.58 nrd=0.029 nrs=0.029 sa=0
+ sb=0 sd=0 mult=4 m=4
XXM_top5 net6 net2 VAPWR VAPWR sky130_fd_pr__pfet_g5v0d10v5 L=2 W=10 nf=1 ad=2.9 as=2.9 pd=20.58 ps=20.58 nrd=0.029 nrs=0.029 sa=0
+ sb=0 sd=0 mult=4 m=4
XXM3 net4 net4 VBE1 0 sky130_fd_pr__nfet_g5v0d10v5 L=2 W=10 nf=1 ad=2.9 as=2.9 pd=20.58 ps=20.58 nrd=0.029 nrs=0.029 sa=0 sb=0
+ sd=0 mult=2 m=2
XXM4 net5 net4 net1 0 sky130_fd_pr__nfet_g5v0d10v5 L=2 W=10 nf=1 ad=2.9 as=2.9 pd=20.58 ps=20.58 nrd=0.029 nrs=0.029 sa=0 sb=0
+ sd=0 mult=2 m=2
XXM_bot1 net4 net7 net3 VAPWR sky130_fd_pr__pfet_g5v0d10v5 L=2 W=10 nf=1 ad=2.9 as=2.9 pd=20.58 ps=20.58 nrd=0.029 nrs=0.029 sa=0
+ sb=0 sd=0 mult=4 m=4
XXM_bot2 net5 net7 net2 VAPWR sky130_fd_pr__pfet_g5v0d10v5 L=2 W=10 nf=1 ad=2.9 as=2.9 pd=20.58 ps=20.58 nrd=0.029 nrs=0.029 sa=0
+ sb=0 sd=0 mult=4 m=4
XXM_bot5 net8 net7 net6 VAPWR sky130_fd_pr__pfet_g5v0d10v5 L=2 W=10 nf=1 ad=2.9 as=2.9 pd=20.58 ps=20.58 nrd=0.029 nrs=0.029 sa=0
+ sb=0 sd=0 mult=4 m=4
XXM_bias net7 net7 VAPWR VAPWR sky130_fd_pr__pfet_g5v0d10v5 L=4 W=10 nf=1 ad=2.9 as=2.9 pd=20.58 ps=20.58 nrd=0.029 nrs=0.029 sa=0
+ sb=0 sd=0 mult=1
R2 net8 0 124k
I_bias net7 0 9.68u
**** begin user architecture code

.nodeset v(vbe1)=0.88 v(net1)=0.88 v(v_ctrl)=1.5
.param R7_val=180k
.save all
.save @r1[i]
.save @r6[i]
.dc temp -40 125 5

.control
  let r_start = 110k
  let r_stop = 130k
  let r_step = 3k
  let r_curr = r_start

  while r_curr <= r_stop
    alterparam R7_val = $&r_curr
    reset
    nodeset v(vbe1)=0.88 v(net1)=0.88 v(v_ctrl)=1.5
    run
    let r_curr = r_curr + r_step
  end

  plot dc1.@r1[i]+dc1.@r6[i] dc2.@r1[i]+dc2.@r6[i] dc3.@r1[i]+dc3.@r6[i] dc4.@r1[i]+dc4.@r6[i] dc5.@r1[i]+dc5.@r6[i] dc6.@r1[i]+dc6.@r6[i] dc7.@r1[i]+dc7.@r6[i]
.endc

** opencircuitdesign pdks install
.lib /foss/pdks/sky130A/libs.tech/combined/sky130.lib.spice tt

**** end user architecture code
**.ends
.end
