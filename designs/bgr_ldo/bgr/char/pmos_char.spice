* PMOS Characterization Template for sky130_fd_pr__pfet_g5v0d10v5
.lib /foss/pdks/sky130A/libs.tech/combined/sky130.lib.spice tt

* ==========================================
* [USER PARAMETERS]
* ==========================================
.param W_val = 10u
.param L_val = 2u
.param M_val = 4
.param I_bias = 9.68u

* ==========================================
* [DEVICE UNDER TEST]
* ==========================================
XM1 d d s b sky130_fd_pr__pfet_g5v0d10v5 w={W_val} l={L_val} m={M_val}

* Supplies
Vs s 0 3.3
Vb b 0 3.3
I1 d 0 {I_bias}

.op
.control
  run
  show xm1  ; displays: vgs, vds, vth, gm, gds(ro), vdsat
  print (3.3 - v(d)) ; Vsg (Vsd)
.endc
.end
