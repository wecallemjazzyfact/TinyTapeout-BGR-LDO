* File: tc_export.spice (Export TC curves for 116k, 120k, 124k)
.lib /foss/pdks/sky130A/libs.tech/combined/sky130.lib.spice tt

* PMOS Main Mirrors (Thick-Ox 5V, m=4)
XM_top1 V_mid1_pmos V_gate_top VAPWR VAPWR sky130_fd_pr__pfet_g5v0d10v5 w=10 l=2 m=4
XM_top2 V_mid2_pmos V_gate_top VAPWR VAPWR sky130_fd_pr__pfet_g5v0d10v5 w=10 l=2 m=4
XM_top5 V_mid5_pmos V_gate_top VAPWR VAPWR sky130_fd_pr__pfet_g5v0d10v5 w=10 l=2 m=4

* PMOS Cascode Transistors (Thick-Ox 5V, m=4)
XM_bot1 V_mid1 V_bias V_mid1_pmos VAPWR sky130_fd_pr__pfet_g5v0d10v5 w=10 l=2 m=4
XM_bot2 V_gate_top V_bias V_mid2_pmos VAPWR sky130_fd_pr__pfet_g5v0d10v5 w=10 l=2 m=4
XM_bot5 VREF_LOW V_bias V_mid5_pmos VAPWR sky130_fd_pr__pfet_g5v0d10v5 w=10 l=2 m=4

* PMOS Wide-Swing Bias (Thick-Ox 5V, L=4u, m=1)
XM_bias V_bias V_bias VAPWR VAPWR sky130_fd_pr__pfet_g5v0d10v5 w=10 l=4 m=1
I_bias V_bias 0 9.68u

* NMOS Equalizers (Thick-Ox 5V, m=2)
XM3 V_mid1 V_mid1 VBE1 0 sky130_fd_pr__nfet_g5v0d10v5 w=10 l=2 m=2
XM4 V_gate_top V_mid1 net1 0 sky130_fd_pr__nfet_g5v0d10v5 w=10 l=2 m=2

* Ideal Passive Core
R1 net1 VBE8 17.7k
R6 VBE1 0 {R7_val}
R7 net1 0 {R7_val}
R2 VREF_LOW 0 124k

* BJT Core (Collector Base Emitter: 0 0 VBE)
XQA 0 0 VBE1 sky130_fd_pr__pnp_05v5_W0p68L0p68 m=1
XQB 0 0 VBE8 sky130_fd_pr__pnp_05v5_W0p68L0p68 m=8

* Supplies
VAPWR VAPWR 0 3.3

* Startup Nodeset
.nodeset v(vbe1)=0.78 v(net1)=0.78 v(v_mid1)=1.95 v(v_gate_top)=2.14 v(v_bias)=1.82

.param R7_val=120k
.dc temp -40 125 0.5

.control
  * Run 116k
  alterparam R7_val = 116k
  reset
  run
  wrdata tc_116k.dat v(vref_low)

  * Run 120k
  alterparam R7_val = 120k
  reset
  run
  wrdata tc_120k.dat v(vref_low)

  * Run 124k
  alterparam R7_val = 124k
  reset
  run
  wrdata tc_124k.dat v(vref_low)
.endc
.end
