** sch_path: /foss/designs/designs/bgr_ldo/bgr/bgr_core_tb2.sch
**.subckt bgr_core_tb2
VSource VAPWR 0 3.3
Vload IB_EA 0 0.95
x1 VAPWR VREF_LOW IB_EA net1 net2 net3 net4 0 bgr_core
Vtrim0 net1 0 1.8
Vtrim1 net2 0 1.8
Vtrim2 net3 0 1.8
Vtrim3 net4 0 1.8
**** begin user architecture code

.save all @m.xxm_su_n1.msky130_fd_pr__nfet_g5v0d10v5[id]
.dc vsource 0 3.3 0.01

.control
  run
  echo ==========================================
  echo TEST 3: VAPWR DC Sweep (0V -> 3.3V)
  echo ==========================================
  plot v(vref_low)
  plot v(sense_out)
  write startup_dc.raw
.endc

** opencircuitdesign pdks install
.lib /foss/pdks/sky130A/libs.tech/combined/sky130.lib.spice tt

**** end user architecture code
**.ends

* expanding   symbol:  bgr_core.sym # of pins=8
** sym_path: /foss/designs/designs/bgr_ldo/bgr/bgr_core.sym
** sch_path: /foss/designs/designs/bgr_ldo/bgr/bgr_core.sch
.subckt bgr_core VAPWR VREF_LOW IB_EA TRIM0 TRIM1 TRIM2 TRIM3 VGND
*.iopin VAPWR
*.opin VREF_LOW
*.iopin VGND
*.opin IB_EA
*.ipin TRIM0
*.ipin TRIM1
*.ipin TRIM2
*.ipin TRIM3
XXQA VGND VGND VBE1 sky130_fd_pr__pnp_05v5_W0p68L0p68 m=1 mult=1
XXQB VGND VGND VBE8 sky130_fd_pr__pnp_05v5_W0p68L0p68 m=8 mult=8
XXM_top1 net2 V_gate_top VAPWR VAPWR sky130_fd_pr__pfet_g5v0d10v5 L=4 W=20 nf=1 ad=5.8 as=5.8 pd=40.58 ps=40.58 nrd=0.0145
+ nrs=0.0145 sa=0 sb=0 sd=0 mult=4 m=4
XXM_top2 net3 V_gate_top VAPWR VAPWR sky130_fd_pr__pfet_g5v0d10v5 L=4 W=20 nf=1 ad=5.8 as=5.8 pd=40.58 ps=40.58 nrd=0.0145
+ nrs=0.0145 sa=0 sb=0 sd=0 mult=4 m=4
XXM_top5 net6 V_gate_top VAPWR VAPWR sky130_fd_pr__pfet_g5v0d10v5 L=4 W=20 nf=1 ad=5.8 as=5.8 pd=40.58 ps=40.58 nrd=0.0145
+ nrs=0.0145 sa=0 sb=0 sd=0 mult=4 m=4
XXM3 net4 V_mid1 VBE1 VGND sky130_fd_pr__nfet_g5v0d10v5 L=4 W=20 nf=1 ad=5.8 as=5.8 pd=40.58 ps=40.58 nrd=0.0145 nrs=0.0145 sa=0
+ sb=0 sd=0 mult=2 m=2
XXM4 net5 V_mid1 net1 VGND sky130_fd_pr__nfet_g5v0d10v5 L=4 W=20 nf=1 ad=5.8 as=5.8 pd=40.58 ps=40.58 nrd=0.0145 nrs=0.0145 sa=0
+ sb=0 sd=0 mult=2 m=2
XXM_bot1 V_mid1 V_bias net2 VAPWR sky130_fd_pr__pfet_g5v0d10v5 L=2 W=10 nf=1 ad=2.9 as=2.9 pd=20.58 ps=20.58 nrd=0.029 nrs=0.029
+ sa=0 sb=0 sd=0 mult=4 m=4
XXM_bot2 V_gate_top V_bias net3 VAPWR sky130_fd_pr__pfet_g5v0d10v5 L=2 W=10 nf=1 ad=2.9 as=2.9 pd=20.58 ps=20.58 nrd=0.029
+ nrs=0.029 sa=0 sb=0 sd=0 mult=4 m=4
XXM_bot5 VREF_LOW V_bias net6 VAPWR sky130_fd_pr__pfet_g5v0d10v5 L=2 W=10 nf=1 ad=2.9 as=2.9 pd=20.58 ps=20.58 nrd=0.029 nrs=0.029
+ sa=0 sb=0 sd=0 mult=4 m=4
XXM_bias V_bias V_bias VAPWR VAPWR sky130_fd_pr__pfet_g5v0d10v5 L=4 W=10 nf=1 ad=2.9 as=2.9 pd=20.58 ps=20.58 nrd=0.029 nrs=0.029
+ sa=0 sb=0 sd=0 mult=1
XXM_bias_mir V_bias_n V_gate_top VAPWR VAPWR sky130_fd_pr__pfet_g5v0d10v5 L=2 W=10 nf=1 ad=2.9 as=2.9 pd=20.58 ps=20.58 nrd=0.029
+ nrs=0.029 sa=0 sb=0 sd=0 mult=4 m=4
XXM_bias_n1 V_bias_n V_bias_n VGND VGND sky130_fd_pr__nfet_g5v0d10v5 L=2 W=10 nf=1 ad=2.9 as=2.9 pd=20.58 ps=20.58 nrd=0.029
+ nrs=0.029 sa=0 sb=0 sd=0 mult=2 m=2
XXM_bias_n2 V_bias V_bias_n VGND VGND sky130_fd_pr__nfet_g5v0d10v5 L=2 W=10 nf=1 ad=2.9 as=2.9 pd=20.58 ps=20.58 nrd=0.029
+ nrs=0.029 sa=0 sb=0 sd=0 mult=2 m=2
XXM_su_n1 V_gate_top sense_out V_su_mid VGND sky130_fd_pr__nfet_g5v0d10v5 L=2 W=1 nf=1 ad=0.29 as=0.29 pd=2.58 ps=2.58 nrd=0.29
+ nrs=0.29 sa=0 sb=0 sd=0 mult=1
XXM_su_n2 V_su_mid V_su_mid VGND VGND sky130_fd_pr__nfet_g5v0d10v5 L=20 W=1 nf=1 ad=0.29 as=0.29 pd=2.58 ps=2.58 nrd=0.29 nrs=0.29
+ sa=0 sb=0 sd=0 mult=1
XXM_pd sense_out VBE1 VGND VGND sky130_fd_pr__nfet_g5v0d10v5 L=2 W=12 nf=1 ad=3.48 as=3.48 pd=24.58 ps=24.58
+ nrd=0.0241666666666667 nrs=0.0241666666666667 sa=0 sb=0 sd=0 mult=1
XXM_su1a sense_out V_bias_n net8 VAPWR sky130_fd_pr__pfet_g5v0d10v5 L=20 W=0.42 nf=1 ad=0.1218 as=0.1218 pd=1.42 ps=1.42
+ nrd=0.69047619047619 nrs=0.69047619047619 sa=0 sb=0 sd=0 mult=1
XXM_su1b net8 V_bias_n net7 VAPWR sky130_fd_pr__pfet_g5v0d10v5 L=20 W=0.42 nf=1 ad=0.1218 as=0.1218 pd=1.42 ps=1.42
+ nrd=0.69047619047619 nrs=0.69047619047619 sa=0 sb=0 sd=0 mult=1
XXM_su1c net7 V_bias_n VAPWR VAPWR sky130_fd_pr__pfet_g5v0d10v5 L=20 W=0.42 nf=1 ad=0.1218 as=0.1218 pd=1.42 ps=1.42
+ nrd=0.69047619047619 nrs=0.69047619047619 sa=0 sb=0 sd=0 mult=1
XR1 VBE8 net1 VGND sky130_fd_pr__res_high_po_0p69 L=34.431 mult=1
XR6 VGND VBE1 VGND sky130_fd_pr__res_high_po_0p69 L=244.537 mult=1
XR7 VGND net1 VGND sky130_fd_pr__res_high_po_0p69 L=244.537 mult=1
XR2fix n_b0 VREF_LOW VGND sky130_fd_pr__res_high_po_0p69 L=229.4050 mult=1
XXM3c V_mid1 V_casc_n net4 VGND sky130_fd_pr__nfet_g5v0d10v5 L=2 W=10 nf=1 ad=2.9 as=2.9 pd=20.58 ps=20.58 nrd=0.029 nrs=0.029
+ sa=0 sb=0 sd=0 mult=2 m=2
XXM4c V_gate_top V_casc_n net5 VGND sky130_fd_pr__nfet_g5v0d10v5 L=2 W=10 nf=1 ad=2.9 as=2.9 pd=20.58 ps=20.58 nrd=0.029 nrs=0.029
+ sa=0 sb=0 sd=0 mult=2 m=2
XXM_cn_mir V_casc_n V_gate_top VAPWR VAPWR sky130_fd_pr__pfet_g5v0d10v5 L=2 W=10 nf=1 ad=2.9 as=2.9 pd=20.58 ps=20.58 nrd=0.029
+ nrs=0.029 sa=0 sb=0 sd=0 mult=1
XXM_cn_d2 V_casc_n V_casc_n cn_mid VGND sky130_fd_pr__nfet_g5v0d10v5 L=2 W=2 nf=1 ad=0.58 as=0.58 pd=4.58 ps=4.58 nrd=0.145
+ nrs=0.145 sa=0 sb=0 sd=0 mult=1
XXM_cn_d1 cn_mid cn_mid net9 VGND sky130_fd_pr__nfet_g5v0d10v5 L=2 W=2 nf=1 ad=0.58 as=0.58 pd=4.58 ps=4.58 nrd=0.145 nrs=0.145
+ sa=0 sb=0 sd=0 mult=1
XR_cn VGND net9 VGND sky130_fd_pr__res_high_po_0p69 L=91.5 mult=1
XXM_tap_top net_tap V_gate_top VAPWR VAPWR sky130_fd_pr__pfet_g5v0d10v5 L=4 W=20 nf=1 ad=5.8 as=5.8 pd=40.58 ps=40.58 nrd=0.0145
+ nrs=0.0145 sa=0 sb=0 sd=0 mult=1
XXM_tap_casc IB_EA V_bias net_tap VAPWR sky130_fd_pr__pfet_g5v0d10v5 L=2 W=10 nf=1 ad=2.9 as=2.9 pd=20.58 ps=20.58 nrd=0.029
+ nrs=0.029 sa=0 sb=0 sd=0 mult=1
XR2b0 n_b1 n_b0 VGND sky130_fd_pr__res_high_po_0p69 L=1.2685 mult=1
XR2b1 n_b2 n_b1 VGND sky130_fd_pr__res_high_po_0p69 L=3.6532 mult=1
XR2b2 n_b3 n_b2 VGND sky130_fd_pr__res_high_po_0p69 L=8.4225 mult=1
XR2b3 VGND n_b3 VGND sky130_fd_pr__res_high_po_0p69 L=17.9612 mult=1
x1 VGND n_b1 n_b0 n_b3 n_b2 TRIM0 TRIM1 TRIM3 TRIM2 VGND n_b3 n_b2 n_b1 trim_sw
.ends

* expanding   symbol:  trim_sw.sym # of pins=13
** sym_path: /foss/designs/designs/bgr_ldo/bgr/trim_sw.sym
** sch_path: /foss/designs/designs/bgr_ldo/bgr/trim_sw.sch
.subckt trim_sw VGND SEG1A SEG0A SEG3A SEG2A TRIM0 TRIM1 TRIM3 TRIM2 SEG3B SEG2B SEG1B SEG0B
*.ipin TRIM0
*.ipin TRIM1
*.ipin TRIM2
*.ipin TRIM3
*.iopin SEG0A
*.iopin SEG0B
*.iopin SEG1A
*.iopin SEG2A
*.iopin SEG3A
*.iopin SEG1B
*.iopin SEG2B
*.iopin SEG3B
*.iopin VGND
XSWb0 SEG0A TRIM0 SEG0B VGND sky130_fd_pr__nfet_01v8 L=0.15 W=10 nf=1 ad=2.9 as=2.9 pd=20.58 ps=20.58 nrd=0.029 nrs=0.029 sa=0
+ sb=0 sd=0 mult=22 m=22
XSWb1 SEG1A TRIM1 SEG1B VGND sky130_fd_pr__nfet_01v8 L=0.15 W=10 nf=1 ad=2.9 as=2.9 pd=20.58 ps=20.58 nrd=0.029 nrs=0.029 sa=0
+ sb=0 sd=0 mult=22 m=22
XSWb2 SEG2A TRIM2 SEG2B VGND sky130_fd_pr__nfet_01v8 L=0.15 W=10 nf=1 ad=2.9 as=2.9 pd=20.58 ps=20.58 nrd=0.029 nrs=0.029 sa=0
+ sb=0 sd=0 mult=22 m=22
XSWb3 SEG3A TRIM3 SEG3B VGND sky130_fd_pr__nfet_01v8 L=0.15 W=10 nf=1 ad=2.9 as=2.9 pd=20.58 ps=20.58 nrd=0.029 nrs=0.029 sa=0
+ sb=0 sd=0 mult=22 m=22
.ends

.end
