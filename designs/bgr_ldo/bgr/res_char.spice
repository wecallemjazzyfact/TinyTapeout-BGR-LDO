* Resistor Characterization for sky130_fd_pr__res_high_po
.lib /foss/pdks/sky130A/libs.tech/combined/sky130.lib.spice tt

* Resistor with W=0.69u, L=16.84u and substrate connected to 0
XR1 d1 s1 0 sky130_fd_pr__res_high_po w=0.69 l=16.84
V1 d1 s1 1.0

.op
.control
  run
  print -i(V1)
  * Let's check at 27C and sweep temp to find TC
  dc temp -40 125 5
  * We will compute resistance: R = 1.0 / -i(V1)
  * Since we sweep temp, the result is in the dc1 plot
  print 1.0 / -i(V1)
.endc
.end
