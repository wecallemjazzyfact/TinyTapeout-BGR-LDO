* NMOS Characterization at V_GS = 0.92V
* Corner selection (default: ss, change to tt if needed)
* .lib /foss/pdks/sky130A/libs.tech/combined/sky130.lib.spice tt
.lib /foss/pdks/sky130A/libs.tech/combined/sky130.lib.spice ss

Vd d 0 1.0
Vg g 0 0.92
Vs s 0 0
Vb b 0 0

XM1 d g s b sky130_fd_pr__nfet_g5v0d10v5 W=4 L=2 nf=1 m=1

.op

.control
  run
  echo ==========================================================
  echo NMOS Characterization (M_pd: W=4, L=2, Vds=1V)
  echo ==========================================================
  print @m.xm1.msky130_fd_pr__nfet_g5v0d10v5[id]
.endc
.end
