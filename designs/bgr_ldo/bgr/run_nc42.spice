** sch_path: /foss/designs/designs/bgr_ldo/sim/bgr_core_tb.sch
**.subckt bgr_core_tb
XXQA 0 0 VBE1 sky130_fd_pr__pnp_05v5_W0p68L0p68 m=1 mult=1
VSource VAPWR 0 3.3
XXQB 0 0 VBE8 sky130_fd_pr__pnp_05v5_W0p68L0p68 m=8 mult=8
XXM_top1 net2 V_gate_top VAPWR VAPWR sky130_fd_pr__pfet_g5v0d10v5 L=2 W=10 nf=1 ad=2.9 as=2.9 pd=20.58 ps=20.58 nrd=0.029
+ nrs=0.029 sa=0 sb=0 sd=0 mult=4 m=4
XXM_top2 net3 V_gate_top VAPWR VAPWR sky130_fd_pr__pfet_g5v0d10v5 L=2 W=10 nf=1 ad=2.9 as=2.9 pd=20.58 ps=20.58 nrd=0.029
+ nrs=0.029 sa=0 sb=0 sd=0 mult=4 m=4
XXM_top5 net6 V_gate_top VAPWR VAPWR sky130_fd_pr__pfet_g5v0d10v5 L=2 W=10 nf=1 ad=2.9 as=2.9 pd=20.58 ps=20.58 nrd=0.029
+ nrs=0.029 sa=0 sb=0 sd=0 mult=4 m=4
XXM3 net4 V_mid1 VBE1 0 sky130_fd_pr__nfet_g5v0d10v5 L=2 W=10 nf=1 ad=2.9 as=2.9 pd=20.58 ps=20.58 nrd=0.029 nrs=0.029 sa=0 sb=0
+ sd=0 mult=2 m=2
XXM4 net5 V_mid1 net1 0 sky130_fd_pr__nfet_g5v0d10v5 L=2 W=10 nf=1 ad=2.9 as=2.9 pd=20.58 ps=20.58 nrd=0.029 nrs=0.029 sa=0 sb=0
+ sd=0 mult=2 m=2
XXM_bot1 V_mid1 V_bias net2 VAPWR sky130_fd_pr__pfet_g5v0d10v5 L=2 W=10 nf=1 ad=2.9 as=2.9 pd=20.58 ps=20.58 nrd=0.029 nrs=0.029
+ sa=0 sb=0 sd=0 mult=4 m=4
XXM_bot2 V_gate_top V_bias net3 VAPWR sky130_fd_pr__pfet_g5v0d10v5 L=2 W=10 nf=1 ad=2.9 as=2.9 pd=20.58 ps=20.58 nrd=0.029
+ nrs=0.029 sa=0 sb=0 sd=0 mult=4 m=4
XXM_bot5 VREF_LOW V_bias net6 VAPWR sky130_fd_pr__pfet_g5v0d10v5 L=2 W=10 nf=1 ad=2.9 as=2.9 pd=20.58 ps=20.58 nrd=0.029 nrs=0.029
+ sa=0 sb=0 sd=0 mult=4 m=4
XXM_bias V_bias V_bias VAPWR VAPWR sky130_fd_pr__pfet_g5v0d10v5 L=4 W=10 nf=1 ad=2.9 as=2.9 pd=20.58 ps=20.58 nrd=0.029 nrs=0.029
+ sa=0 sb=0 sd=0 mult=1
XXM_bias_mir V_bias_n V_gate_top VAPWR VAPWR sky130_fd_pr__pfet_g5v0d10v5 L=2 W=10 nf=1 ad=2.9 as=2.9 pd=20.58 ps=20.58 nrd=0.029
+ nrs=0.029 sa=0 sb=0 sd=0 mult=4 m=4
XXM_bias_n1 V_bias_n V_bias_n 0 0 sky130_fd_pr__nfet_g5v0d10v5 L=2 W=10 nf=1 ad=2.9 as=2.9 pd=20.58 ps=20.58 nrd=0.029 nrs=0.029
+ sa=0 sb=0 sd=0 mult=2 m=2
XXM_bias_n2 V_bias V_bias_n 0 0 sky130_fd_pr__nfet_g5v0d10v5 L=2 W=10 nf=1 ad=2.9 as=2.9 pd=20.58 ps=20.58 nrd=0.029 nrs=0.029
+ sa=0 sb=0 sd=0 mult=2 m=2
XXM_su_n1 V_gate_top sense_out V_su_mid 0 sky130_fd_pr__nfet_g5v0d10v5 L=2 W=1 nf=1 ad=0.29 as=0.29 pd=2.58 ps=2.58 nrd=0.29
+ nrs=0.29 sa=0 sb=0 sd=0 mult=1
XXM_su_n2 V_su_mid V_su_mid 0 0 sky130_fd_pr__nfet_g5v0d10v5 L=20 W=1 nf=1 ad=0.29 as=0.29 pd=2.58 ps=2.58 nrd=0.29 nrs=0.29 sa=0
+ sb=0 sd=0 mult=1
XXM_pd sense_out VBE1 0 0 sky130_fd_pr__nfet_g5v0d10v5 L=2 W=12 nf=1 ad=3.48 as=3.48 pd=24.58 ps=24.58 nrd=0.0241666666666667
+ nrs=0.0241666666666667 sa=0 sb=0 sd=0 mult=1
XXM_su1a sense_out V_bias_n net8 VAPWR sky130_fd_pr__pfet_g5v0d10v5 L=20 W=0.42 nf=1 ad=0.1218 as=0.1218 pd=1.42 ps=1.42
+ nrd=0.69047619047619 nrs=0.69047619047619 sa=0 sb=0 sd=0 mult=1
XXM_su1b net8 V_bias_n net7 VAPWR sky130_fd_pr__pfet_g5v0d10v5 L=20 W=0.42 nf=1 ad=0.1218 as=0.1218 pd=1.42 ps=1.42
+ nrd=0.69047619047619 nrs=0.69047619047619 sa=0 sb=0 sd=0 mult=1
XXM_su1c net7 V_bias_n VAPWR VAPWR sky130_fd_pr__pfet_g5v0d10v5 L=20 W=0.42 nf=1 ad=0.1218 as=0.1218 pd=1.42 ps=1.42
+ nrd=0.69047619047619 nrs=0.69047619047619 sa=0 sb=0 sd=0 mult=1
XR1 VBE8 net1 0 sky130_fd_pr__res_high_po_0p69 L=34.431 mult=1
XR6 0 VBE1 0 sky130_fd_pr__res_high_po_0p69 L=250.540 mult=1
XR7 0 net1 0 sky130_fd_pr__res_high_po_0p69 L=250.540 mult=1
XR2 0 VREF_LOW 0 sky130_fd_pr__res_high_po_0p69 L=244.537 mult=1
XXM3c V_mid1 V_casc_n net4 0 sky130_fd_pr__nfet_g5v0d10v5 L=2 W=10 nf=1 ad=2.9 as=2.9 pd=20.58 ps=20.58 nrd=0.029 nrs=0.029 sa=0
+ sb=0 sd=0 mult=2 m=2
XXM4c V_gate_top V_casc_n net5 0 sky130_fd_pr__nfet_g5v0d10v5 L=2 W=10 nf=1 ad=2.9 as=2.9 pd=20.58 ps=20.58 nrd=0.029 nrs=0.029
+ sa=0 sb=0 sd=0 mult=2 m=2
XXM_cn_mir V_casc_n V_gate_top VAPWR VAPWR sky130_fd_pr__pfet_g5v0d10v5 L=2 W=10 nf=1 ad=2.9 as=2.9 pd=20.58 ps=20.58 nrd=0.029
+ nrs=0.029 sa=0 sb=0 sd=0 mult=1
XXM_cn_d2 V_casc_n V_casc_n cn_mid net9 sky130_fd_pr__nfet_g5v0d10v5 L=2 W=2 nf=1 ad=0.58 as=0.58 pd=4.58 ps=4.58 nrd=0.145
+ nrs=0.145 sa=0 sb=0 sd=0 mult=1
XXM_cn_d1 cn_mid cn_mid net9 net9 sky130_fd_pr__nfet_g5v0d10v5 L=2 W=2 nf=1 ad=0.58 as=0.58 pd=4.58 ps=4.58 nrd=0.145 nrs=0.145
+ sa=0 sb=0 sd=0 mult=1
XR_cn 0 net9 0 sky130_fd_pr__res_high_po_0p69 L=91.5 mult=1
**** begin user architecture code

.save all @m.xxm_su_n1.msky130_fd_pr__nfet_g5v0d10v5[id]
.dc temp -40 125 2

.control
run
wrdata nc42.csv v(vref_low)
echo DONE_N42
.endc

** opencircuitdesign pdks install
.lib /foss/pdks/sky130A/libs.tech/combined/sky130.lib.spice tt

**** end user architecture code
**.ends
.end
