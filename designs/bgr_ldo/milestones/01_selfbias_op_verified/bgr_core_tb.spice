** sch_path: /foss/designs/designs/bgr_ldo/sim/bgr_core_tb.sch
**.subckt bgr_core_tb
XQA 0 0 VBE1 sky130_fd_pr__pnp_05v5_W0p68L0p68 m=1 mult=1
VSource VAPWR 0 3.3
XQB 0 0 VBE8 sky130_fd_pr__pnp_05v5_W0p68L0p68 m=8 mult=8
R1 net1 VBE8 17.7k
R7 net1 0 {R7_val}
R6 VBE1 0 {R7_val}
E1 V_ctrl 0 VBE1 net1 1e5
B1 VAPWR VBE1 I = 10u * V(V_ctrl) * u(V(V_ctrl))
B2 VAPWR net1 I = 10u * V(V_ctrl) * u(V(V_ctrl))
**** begin user architecture code

.nodeset v(vbe1)=0.75 v(net1)=0.75 v(v_ctrl)=1.0
.param R7_val=180k
.save all

.control
  * R7 스윕 루프는 주석 처리
  * let r_start = 120k
  * let r_stop = 250k
  * let r_step = 20k
  * let r_curr = r_start
  * while r_curr <= r_stop
  *   alterparam R7_val = $&r_curr
  *   reset
  *   run
  *   let r_curr = r_curr + r_step
  * end

  * 27도 단일 동작점 해석 실행
  op

  * 결과 보고용 데이터 출력 (에러 방지용 수식 적용)
  print v(vbe1) v(net1) (v(vbe1)-v(net1)) v(v_ctrl) v(vbe8)
  print (v(vbe1)/180k) ((v(net1)-v(vbe8))/17.7k) ((v(vbe1)/180k) + ((v(net1)-v(vbe8))/17.7k))
.endc

** opencircuitdesign pdks install
.lib /foss/pdks/sky130A/libs.tech/combined/sky130.lib.spice tt

**** end user architecture code
**.ends
.end
