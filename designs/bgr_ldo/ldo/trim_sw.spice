** sch_path: /foss/designs/designs/bgr_ldo/bgr/trim_sw.sch
**.subckt trim_sw VGND SEG1A SEG0A SEG3A SEG2A TRIM0 TRIM1 TRIM3 TRIM2 SEG3B SEG2B SEG1B SEG0B
*.ipin TRIM0
*.ipin TRIM1
*.ipin TRIM2
*.ipin TRIM3
*.iopin SEG0A
*.iopin SEG0B
*.iopin SEG1A
*.iopin SEG2A
*.iopin SEG3A
*.iopin SEG1B
*.iopin SEG2B
*.iopin SEG3B
*.iopin VGND
XSWb0 SEG0A TRIM0 SEG0B VGND sky130_fd_pr__nfet_01v8 L=0.15 W=10 nf=1 ad=2.9 as=2.9 pd=20.58 ps=20.58 nrd=0.029 nrs=0.029 sa=0
+ sb=0 sd=0 mult=22 m=22
XSWb1 SEG1A TRIM1 SEG1B VGND sky130_fd_pr__nfet_01v8 L=0.15 W=10 nf=1 ad=2.9 as=2.9 pd=20.58 ps=20.58 nrd=0.029 nrs=0.029 sa=0
+ sb=0 sd=0 mult=22 m=22
XSWb2 SEG2A TRIM2 SEG2B VGND sky130_fd_pr__nfet_01v8 L=0.15 W=10 nf=1 ad=2.9 as=2.9 pd=20.58 ps=20.58 nrd=0.029 nrs=0.029 sa=0
+ sb=0 sd=0 mult=22 m=22
XSWb3 SEG3A TRIM3 SEG3B VGND sky130_fd_pr__nfet_01v8 L=0.15 W=10 nf=1 ad=2.9 as=2.9 pd=20.58 ps=20.58 nrd=0.029 nrs=0.029 sa=0
+ sb=0 sd=0 mult=22 m=22
**.ends
.end
